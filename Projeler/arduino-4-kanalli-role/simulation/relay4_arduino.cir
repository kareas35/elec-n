* 4 kanal röle kartı - Arduino PWL sürüşü
* KiCad eeschema veya ngspice ile çalıştırılabilir
.tran 0 8 0 2m
VCC 5 0 DC 5
.model SMOD VSWITCH(Ron=0.5 Roff=1Meg Von=2.5 Voff=0.5)
.model DCLAMP D(Is=1u N=1.5)
.model DLED D(Is=1u N=1.5)
VIN1 IN1 0 PWL(0 0 0.5000 0 0.5000 5 1.0000 5 1.0000 0 2.5000 0 2.5000 5 3.0000 5 3.0000 0 4.0000 0 4.0000 5 4.2500 5 4.2500 0 5.0000 0 5.0000 5 5.2500 5 5.2500 0 5.5000 0 5.5000 5 5.7500 5 5.7500 0 8 0)
RCOIL1 5 C1A 70
LCOIL1 C1A C1B 120m
S1 C1B 0 IN1 0 SMOD
D1 C1B 5 DCLAMP
RLED1 5 L1A 1k
DLED1 L1A C1B DLED
VIN2 IN2 0 PWL(0 0 1.0000 0 1.0000 5 1.5000 5 1.5000 0 2.5000 0 2.5000 5 3.0000 5 3.0000 0 4.2500 0 4.2500 5 4.5000 5 4.5000 0 5.2500 0 5.2500 5 5.5000 5 5.5000 0 5.7500 0 5.7500 5 6.0000 5 6.0000 0 8 0)
RCOIL2 5 C2A 70
LCOIL2 C2A C2B 120m
S2 C2B 0 IN2 0 SMOD
D2 C2B 5 DCLAMP
RLED2 5 L2A 1k
DLED2 L2A C2B DLED
VIN3 IN3 0 PWL(0 0 1.5000 0 1.5000 5 2.0000 5 2.0000 0 2.5000 0 2.5000 5 3.0000 5 3.0000 0 4.5000 0 4.5000 5 4.7500 5 4.7500 0 5.0000 0 5.0000 5 5.2500 5 5.2500 0 5.5000 0 5.5000 5 5.7500 5 5.7500 0 8 0)
RCOIL3 5 C3A 70
LCOIL3 C3A C3B 120m
S3 C3B 0 IN3 0 SMOD
D3 C3B 5 DCLAMP
RLED3 5 L3A 1k
DLED3 L3A C3B DLED
VIN4 IN4 0 PWL(0 0 2.0000 0 2.0000 5 3.0000 5 3.0000 0 4.7500 0 4.7500 5 5.0000 5 5.0000 0 5.2500 0 5.2500 5 5.5000 5 5.5000 0 5.7500 0 5.7500 5 6.0000 5 6.0000 0 8 0)
RCOIL4 5 C4A 70
LCOIL4 C4A C4B 120m
S4 C4B 0 IN4 0 SMOD
D4 C4B 5 DCLAMP
RLED4 5 L4A 1k
DLED4 L4A C4B DLED
.end
